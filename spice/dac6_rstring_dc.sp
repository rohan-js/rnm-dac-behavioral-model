* 6-bit SKY130 R-string DAC - DC bench TEMPLATE (one run per code)
* generated by tools/gen_dac_netlist.py; @GN<k>@/@GP<k>@ placeholders
* are filled by tools/run_dc_sweep.py
.param sky130_fd_pr__res_high_po__var = 0
.param sky130_fd_pr__res_high_po__slope_spectre = 0
.param sky130_fd_pr__res_high_po__con_slope_spectre = 0
.param tc1rpolybody = 0
.param tc2rpolybody = 0
.param sky130_fd_pr__pfet_01v8__wlod_diff = 0
.param sky130_fd_pr__pfet_01v8__kvth0_diff = 0
.param sky130_fd_pr__pfet_01v8__lkvth0_diff = 0
.param sky130_fd_pr__pfet_01v8__wkvth0_diff = 0
.param sky130_fd_pr__pfet_01v8__ku0_diff = 0
.param sky130_fd_pr__pfet_01v8__lku0_diff = 0
.param sky130_fd_pr__pfet_01v8__wku0_diff = 0
.param sky130_fd_pr__pfet_01v8__kvsat_diff = 0

.include "models/sky130/sky130_fd_pr__nfet_01v8__tt.corner.spice"
.include "models/sky130/sky130_fd_pr__nfet_01v8__mismatch.corner.spice"
.include "models/sky130/sky130_fd_pr__pfet_01v8__tt.corner.spice"
.include "models/sky130/sky130_fd_pr__pfet_01v8__mismatch.corner.spice"
.include "models/sky130/sky130_fd_pr__res_high_po.model.spice"
.include "models/sky130/parasitic_res_po_stub.sp"

Vvref vref 0 DC 3.3
Xr0 vref n1 0 sky130_fd_pr__res_high_po w=1 l=1 rsheet={rsheet_body*(1+0.001394)}
Xr1 n1 n2 0 sky130_fd_pr__res_high_po w=1 l=1 rsheet={rsheet_body*(1-0.004750)}
Xr2 n2 n3 0 sky130_fd_pr__res_high_po w=1 l=1 rsheet={rsheet_body*(1-0.002250)}
Xr3 n3 n4 0 sky130_fd_pr__res_high_po w=1 l=1 rsheet={rsheet_body*(1-0.002768)}
Xr4 n4 n5 0 sky130_fd_pr__res_high_po w=1 l=1 rsheet={rsheet_body*(1+0.002365)}
Xr5 n5 n6 0 sky130_fd_pr__res_high_po w=1 l=1 rsheet={rsheet_body*(1+0.001767)}
Xr6 n6 n7 0 sky130_fd_pr__res_high_po w=1 l=1 rsheet={rsheet_body*(1+0.003922)}
Xr7 n7 n8 0 sky130_fd_pr__res_high_po w=1 l=1 rsheet={rsheet_body*(1-0.004131)}
Xr8 n8 n9 0 sky130_fd_pr__res_high_po w=1 l=1 rsheet={rsheet_body*(1-0.000781)}
Xr9 n9 n10 0 sky130_fd_pr__res_high_po w=1 l=1 rsheet={rsheet_body*(1-0.004702)}
Xr10 n10 n11 0 sky130_fd_pr__res_high_po w=1 l=1 rsheet={rsheet_body*(1-0.002814)}
Xr11 n11 n12 0 sky130_fd_pr__res_high_po w=1 l=1 rsheet={rsheet_body*(1+0.000054)}
Xr12 n12 n13 0 sky130_fd_pr__res_high_po w=1 l=1 rsheet={rsheet_body*(1-0.004735)}
Xr13 n13 n14 0 sky130_fd_pr__res_high_po w=1 l=1 rsheet={rsheet_body*(1-0.003012)}
Xr14 n14 n15 0 sky130_fd_pr__res_high_po w=1 l=1 rsheet={rsheet_body*(1+0.001499)}
Xr15 n15 n16 0 sky130_fd_pr__res_high_po w=1 l=1 rsheet={rsheet_body*(1+0.000449)}
Xr16 n16 n17 0 sky130_fd_pr__res_high_po w=1 l=1 rsheet={rsheet_body*(1-0.002796)}
Xr17 n17 n18 0 sky130_fd_pr__res_high_po w=1 l=1 rsheet={rsheet_body*(1+0.000893)}
Xr18 n18 n19 0 sky130_fd_pr__res_high_po w=1 l=1 rsheet={rsheet_body*(1+0.003094)}
Xr19 n19 n20 0 sky130_fd_pr__res_high_po w=1 l=1 rsheet={rsheet_body*(1-0.004935)}
Xr20 n20 n21 0 sky130_fd_pr__res_high_po w=1 l=1 rsheet={rsheet_body*(1+0.003058)}
Xr21 n21 n22 0 sky130_fd_pr__res_high_po w=1 l=1 rsheet={rsheet_body*(1+0.001981)}
Xr22 n22 n23 0 sky130_fd_pr__res_high_po w=1 l=1 rsheet={rsheet_body*(1-0.001597)}
Xr23 n23 n24 0 sky130_fd_pr__res_high_po w=1 l=1 rsheet={rsheet_body*(1-0.003445)}
Xr24 n24 n25 0 sky130_fd_pr__res_high_po w=1 l=1 rsheet={rsheet_body*(1+0.004572)}
Xr25 n25 n26 0 sky130_fd_pr__res_high_po w=1 l=1 rsheet={rsheet_body*(1-0.001634)}
Xr26 n26 n27 0 sky130_fd_pr__res_high_po w=1 l=1 rsheet={rsheet_body*(1-0.004073)}
Xr27 n27 n28 0 sky130_fd_pr__res_high_po w=1 l=1 rsheet={rsheet_body*(1-0.004033)}
Xr28 n28 n29 0 sky130_fd_pr__res_high_po w=1 l=1 rsheet={rsheet_body*(1+0.003475)}
Xr29 n29 n30 0 sky130_fd_pr__res_high_po w=1 l=1 rsheet={rsheet_body*(1+0.001037)}
Xr30 n30 n31 0 sky130_fd_pr__res_high_po w=1 l=1 rsheet={rsheet_body*(1+0.003071)}
Xr31 n31 n32 0 sky130_fd_pr__res_high_po w=1 l=1 rsheet={rsheet_body*(1+0.002297)}
Xr32 n32 n33 0 sky130_fd_pr__res_high_po w=1 l=1 rsheet={rsheet_body*(1+0.000362)}
Xr33 n33 n34 0 sky130_fd_pr__res_high_po w=1 l=1 rsheet={rsheet_body*(1+0.004731)}
Xr34 n34 n35 0 sky130_fd_pr__res_high_po w=1 l=1 rsheet={rsheet_body*(1-0.001215)}
Xr35 n35 n36 0 sky130_fd_pr__res_high_po w=1 l=1 rsheet={rsheet_body*(1+0.000520)}
Xr36 n36 n37 0 sky130_fd_pr__res_high_po w=1 l=1 rsheet={rsheet_body*(1+0.003294)}
Xr37 n37 n38 0 sky130_fd_pr__res_high_po w=1 l=1 rsheet={rsheet_body*(1+0.001185)}
Xr38 n38 n39 0 sky130_fd_pr__res_high_po w=1 l=1 rsheet={rsheet_body*(1+0.003617)}
Xr39 n39 n40 0 sky130_fd_pr__res_high_po w=1 l=1 rsheet={rsheet_body*(1+0.000774)}
Xr40 n40 n41 0 sky130_fd_pr__res_high_po w=1 l=1 rsheet={rsheet_body*(1+0.002046)}
Xr41 n41 n42 0 sky130_fd_pr__res_high_po w=1 l=1 rsheet={rsheet_body*(1-0.004542)}
Xr42 n42 n43 0 sky130_fd_pr__res_high_po w=1 l=1 rsheet={rsheet_body*(1-0.002721)}
Xr43 n43 n44 0 sky130_fd_pr__res_high_po w=1 l=1 rsheet={rsheet_body*(1-0.002106)}
Xr44 n44 n45 0 sky130_fd_pr__res_high_po w=1 l=1 rsheet={rsheet_body*(1-0.004202)}
Xr45 n45 n46 0 sky130_fd_pr__res_high_po w=1 l=1 rsheet={rsheet_body*(1-0.002672)}
Xr46 n46 n47 0 sky130_fd_pr__res_high_po w=1 l=1 rsheet={rsheet_body*(1-0.003990)}
Xr47 n47 n48 0 sky130_fd_pr__res_high_po w=1 l=1 rsheet={rsheet_body*(1-0.002220)}
Xr48 n48 n49 0 sky130_fd_pr__res_high_po w=1 l=1 rsheet={rsheet_body*(1+0.001357)}
Xr49 n49 n50 0 sky130_fd_pr__res_high_po w=1 l=1 rsheet={rsheet_body*(1-0.001352)}
Xr50 n50 n51 0 sky130_fd_pr__res_high_po w=1 l=1 rsheet={rsheet_body*(1-0.001298)}
Xr51 n51 n52 0 sky130_fd_pr__res_high_po w=1 l=1 rsheet={rsheet_body*(1-0.002905)}
Xr52 n52 n53 0 sky130_fd_pr__res_high_po w=1 l=1 rsheet={rsheet_body*(1-0.002330)}
Xr53 n53 n54 0 sky130_fd_pr__res_high_po w=1 l=1 rsheet={rsheet_body*(1+0.004367)}
Xr54 n54 n55 0 sky130_fd_pr__res_high_po w=1 l=1 rsheet={rsheet_body*(1+0.001480)}
Xr55 n55 n56 0 sky130_fd_pr__res_high_po w=1 l=1 rsheet={rsheet_body*(1+0.001091)}
Xr56 n56 n57 0 sky130_fd_pr__res_high_po w=1 l=1 rsheet={rsheet_body*(1-0.003289)}
Xr57 n57 n58 0 sky130_fd_pr__res_high_po w=1 l=1 rsheet={rsheet_body*(1+0.002291)}
Xr58 n58 n59 0 sky130_fd_pr__res_high_po w=1 l=1 rsheet={rsheet_body*(1-0.003366)}
Xr59 n59 n60 0 sky130_fd_pr__res_high_po w=1 l=1 rsheet={rsheet_body*(1-0.001205)}
Xr60 n60 n61 0 sky130_fd_pr__res_high_po w=1 l=1 rsheet={rsheet_body*(1+0.004895)}
Xr61 n61 n62 0 sky130_fd_pr__res_high_po w=1 l=1 rsheet={rsheet_body*(1+0.001400)}
Xr62 n62 n63 0 sky130_fd_pr__res_high_po w=1 l=1 rsheet={rsheet_body*(1+0.000569)}
Xr63 n63 0 0 sky130_fd_pr__res_high_po w=1 l=1 rsheet={rsheet_body*(1+0.001846)}
.param rsheet_body = 317.3885
Vgn0 gn0 0 DC @GN0@
Vgp0 gp0 0 DC @GP0@
Xntg0 out gn0 0 0 sky130_fd_pr__nfet_01v8 w=1.1u l=0.16u
Xptg0 out gp0 0 vref sky130_fd_pr__pfet_01v8 w=1.1u l=0.16u
Vgn1 gn1 0 DC @GN1@
Vgp1 gp1 0 DC @GP1@
Xntg1 out gn1 n63 0 sky130_fd_pr__nfet_01v8 w=1.1u l=0.16u
Xptg1 out gp1 n63 vref sky130_fd_pr__pfet_01v8 w=1.1u l=0.16u
Vgn2 gn2 0 DC @GN2@
Vgp2 gp2 0 DC @GP2@
Xntg2 out gn2 n62 0 sky130_fd_pr__nfet_01v8 w=1.1u l=0.16u
Xptg2 out gp2 n62 vref sky130_fd_pr__pfet_01v8 w=1.1u l=0.16u
Vgn3 gn3 0 DC @GN3@
Vgp3 gp3 0 DC @GP3@
Xntg3 out gn3 n61 0 sky130_fd_pr__nfet_01v8 w=1.1u l=0.16u
Xptg3 out gp3 n61 vref sky130_fd_pr__pfet_01v8 w=1.1u l=0.16u
Vgn4 gn4 0 DC @GN4@
Vgp4 gp4 0 DC @GP4@
Xntg4 out gn4 n60 0 sky130_fd_pr__nfet_01v8 w=1.1u l=0.16u
Xptg4 out gp4 n60 vref sky130_fd_pr__pfet_01v8 w=1.1u l=0.16u
Vgn5 gn5 0 DC @GN5@
Vgp5 gp5 0 DC @GP5@
Xntg5 out gn5 n59 0 sky130_fd_pr__nfet_01v8 w=1.1u l=0.16u
Xptg5 out gp5 n59 vref sky130_fd_pr__pfet_01v8 w=1.1u l=0.16u
Vgn6 gn6 0 DC @GN6@
Vgp6 gp6 0 DC @GP6@
Xntg6 out gn6 n58 0 sky130_fd_pr__nfet_01v8 w=1.1u l=0.16u
Xptg6 out gp6 n58 vref sky130_fd_pr__pfet_01v8 w=1.1u l=0.16u
Vgn7 gn7 0 DC @GN7@
Vgp7 gp7 0 DC @GP7@
Xntg7 out gn7 n57 0 sky130_fd_pr__nfet_01v8 w=1.1u l=0.16u
Xptg7 out gp7 n57 vref sky130_fd_pr__pfet_01v8 w=1.1u l=0.16u
Vgn8 gn8 0 DC @GN8@
Vgp8 gp8 0 DC @GP8@
Xntg8 out gn8 n56 0 sky130_fd_pr__nfet_01v8 w=1.1u l=0.16u
Xptg8 out gp8 n56 vref sky130_fd_pr__pfet_01v8 w=1.1u l=0.16u
Vgn9 gn9 0 DC @GN9@
Vgp9 gp9 0 DC @GP9@
Xntg9 out gn9 n55 0 sky130_fd_pr__nfet_01v8 w=1.1u l=0.16u
Xptg9 out gp9 n55 vref sky130_fd_pr__pfet_01v8 w=1.1u l=0.16u
Vgn10 gn10 0 DC @GN10@
Vgp10 gp10 0 DC @GP10@
Xntg10 out gn10 n54 0 sky130_fd_pr__nfet_01v8 w=1.1u l=0.16u
Xptg10 out gp10 n54 vref sky130_fd_pr__pfet_01v8 w=1.1u l=0.16u
Vgn11 gn11 0 DC @GN11@
Vgp11 gp11 0 DC @GP11@
Xntg11 out gn11 n53 0 sky130_fd_pr__nfet_01v8 w=1.1u l=0.16u
Xptg11 out gp11 n53 vref sky130_fd_pr__pfet_01v8 w=1.1u l=0.16u
Vgn12 gn12 0 DC @GN12@
Vgp12 gp12 0 DC @GP12@
Xntg12 out gn12 n52 0 sky130_fd_pr__nfet_01v8 w=1.1u l=0.16u
Xptg12 out gp12 n52 vref sky130_fd_pr__pfet_01v8 w=1.1u l=0.16u
Vgn13 gn13 0 DC @GN13@
Vgp13 gp13 0 DC @GP13@
Xntg13 out gn13 n51 0 sky130_fd_pr__nfet_01v8 w=1.1u l=0.16u
Xptg13 out gp13 n51 vref sky130_fd_pr__pfet_01v8 w=1.1u l=0.16u
Vgn14 gn14 0 DC @GN14@
Vgp14 gp14 0 DC @GP14@
Xntg14 out gn14 n50 0 sky130_fd_pr__nfet_01v8 w=1.1u l=0.16u
Xptg14 out gp14 n50 vref sky130_fd_pr__pfet_01v8 w=1.1u l=0.16u
Vgn15 gn15 0 DC @GN15@
Vgp15 gp15 0 DC @GP15@
Xntg15 out gn15 n49 0 sky130_fd_pr__nfet_01v8 w=1.1u l=0.16u
Xptg15 out gp15 n49 vref sky130_fd_pr__pfet_01v8 w=1.1u l=0.16u
Vgn16 gn16 0 DC @GN16@
Vgp16 gp16 0 DC @GP16@
Xntg16 out gn16 n48 0 sky130_fd_pr__nfet_01v8 w=1.1u l=0.16u
Xptg16 out gp16 n48 vref sky130_fd_pr__pfet_01v8 w=1.1u l=0.16u
Vgn17 gn17 0 DC @GN17@
Vgp17 gp17 0 DC @GP17@
Xntg17 out gn17 n47 0 sky130_fd_pr__nfet_01v8 w=1.1u l=0.16u
Xptg17 out gp17 n47 vref sky130_fd_pr__pfet_01v8 w=1.1u l=0.16u
Vgn18 gn18 0 DC @GN18@
Vgp18 gp18 0 DC @GP18@
Xntg18 out gn18 n46 0 sky130_fd_pr__nfet_01v8 w=1.1u l=0.16u
Xptg18 out gp18 n46 vref sky130_fd_pr__pfet_01v8 w=1.1u l=0.16u
Vgn19 gn19 0 DC @GN19@
Vgp19 gp19 0 DC @GP19@
Xntg19 out gn19 n45 0 sky130_fd_pr__nfet_01v8 w=1.1u l=0.16u
Xptg19 out gp19 n45 vref sky130_fd_pr__pfet_01v8 w=1.1u l=0.16u
Vgn20 gn20 0 DC @GN20@
Vgp20 gp20 0 DC @GP20@
Xntg20 out gn20 n44 0 sky130_fd_pr__nfet_01v8 w=1.1u l=0.16u
Xptg20 out gp20 n44 vref sky130_fd_pr__pfet_01v8 w=1.1u l=0.16u
Vgn21 gn21 0 DC @GN21@
Vgp21 gp21 0 DC @GP21@
Xntg21 out gn21 n43 0 sky130_fd_pr__nfet_01v8 w=1.1u l=0.16u
Xptg21 out gp21 n43 vref sky130_fd_pr__pfet_01v8 w=1.1u l=0.16u
Vgn22 gn22 0 DC @GN22@
Vgp22 gp22 0 DC @GP22@
Xntg22 out gn22 n42 0 sky130_fd_pr__nfet_01v8 w=1.1u l=0.16u
Xptg22 out gp22 n42 vref sky130_fd_pr__pfet_01v8 w=1.1u l=0.16u
Vgn23 gn23 0 DC @GN23@
Vgp23 gp23 0 DC @GP23@
Xntg23 out gn23 n41 0 sky130_fd_pr__nfet_01v8 w=1.1u l=0.16u
Xptg23 out gp23 n41 vref sky130_fd_pr__pfet_01v8 w=1.1u l=0.16u
Vgn24 gn24 0 DC @GN24@
Vgp24 gp24 0 DC @GP24@
Xntg24 out gn24 n40 0 sky130_fd_pr__nfet_01v8 w=1.1u l=0.16u
Xptg24 out gp24 n40 vref sky130_fd_pr__pfet_01v8 w=1.1u l=0.16u
Vgn25 gn25 0 DC @GN25@
Vgp25 gp25 0 DC @GP25@
Xntg25 out gn25 n39 0 sky130_fd_pr__nfet_01v8 w=1.1u l=0.16u
Xptg25 out gp25 n39 vref sky130_fd_pr__pfet_01v8 w=1.1u l=0.16u
Vgn26 gn26 0 DC @GN26@
Vgp26 gp26 0 DC @GP26@
Xntg26 out gn26 n38 0 sky130_fd_pr__nfet_01v8 w=1.1u l=0.16u
Xptg26 out gp26 n38 vref sky130_fd_pr__pfet_01v8 w=1.1u l=0.16u
Vgn27 gn27 0 DC @GN27@
Vgp27 gp27 0 DC @GP27@
Xntg27 out gn27 n37 0 sky130_fd_pr__nfet_01v8 w=1.1u l=0.16u
Xptg27 out gp27 n37 vref sky130_fd_pr__pfet_01v8 w=1.1u l=0.16u
Vgn28 gn28 0 DC @GN28@
Vgp28 gp28 0 DC @GP28@
Xntg28 out gn28 n36 0 sky130_fd_pr__nfet_01v8 w=1.1u l=0.16u
Xptg28 out gp28 n36 vref sky130_fd_pr__pfet_01v8 w=1.1u l=0.16u
Vgn29 gn29 0 DC @GN29@
Vgp29 gp29 0 DC @GP29@
Xntg29 out gn29 n35 0 sky130_fd_pr__nfet_01v8 w=1.1u l=0.16u
Xptg29 out gp29 n35 vref sky130_fd_pr__pfet_01v8 w=1.1u l=0.16u
Vgn30 gn30 0 DC @GN30@
Vgp30 gp30 0 DC @GP30@
Xntg30 out gn30 n34 0 sky130_fd_pr__nfet_01v8 w=1.1u l=0.16u
Xptg30 out gp30 n34 vref sky130_fd_pr__pfet_01v8 w=1.1u l=0.16u
Vgn31 gn31 0 DC @GN31@
Vgp31 gp31 0 DC @GP31@
Xntg31 out gn31 n33 0 sky130_fd_pr__nfet_01v8 w=1.1u l=0.16u
Xptg31 out gp31 n33 vref sky130_fd_pr__pfet_01v8 w=1.1u l=0.16u
Vgn32 gn32 0 DC @GN32@
Vgp32 gp32 0 DC @GP32@
Xntg32 out gn32 n32 0 sky130_fd_pr__nfet_01v8 w=1.1u l=0.16u
Xptg32 out gp32 n32 vref sky130_fd_pr__pfet_01v8 w=1.1u l=0.16u
Vgn33 gn33 0 DC @GN33@
Vgp33 gp33 0 DC @GP33@
Xntg33 out gn33 n31 0 sky130_fd_pr__nfet_01v8 w=1.1u l=0.16u
Xptg33 out gp33 n31 vref sky130_fd_pr__pfet_01v8 w=1.1u l=0.16u
Vgn34 gn34 0 DC @GN34@
Vgp34 gp34 0 DC @GP34@
Xntg34 out gn34 n30 0 sky130_fd_pr__nfet_01v8 w=1.1u l=0.16u
Xptg34 out gp34 n30 vref sky130_fd_pr__pfet_01v8 w=1.1u l=0.16u
Vgn35 gn35 0 DC @GN35@
Vgp35 gp35 0 DC @GP35@
Xntg35 out gn35 n29 0 sky130_fd_pr__nfet_01v8 w=1.1u l=0.16u
Xptg35 out gp35 n29 vref sky130_fd_pr__pfet_01v8 w=1.1u l=0.16u
Vgn36 gn36 0 DC @GN36@
Vgp36 gp36 0 DC @GP36@
Xntg36 out gn36 n28 0 sky130_fd_pr__nfet_01v8 w=1.1u l=0.16u
Xptg36 out gp36 n28 vref sky130_fd_pr__pfet_01v8 w=1.1u l=0.16u
Vgn37 gn37 0 DC @GN37@
Vgp37 gp37 0 DC @GP37@
Xntg37 out gn37 n27 0 sky130_fd_pr__nfet_01v8 w=1.1u l=0.16u
Xptg37 out gp37 n27 vref sky130_fd_pr__pfet_01v8 w=1.1u l=0.16u
Vgn38 gn38 0 DC @GN38@
Vgp38 gp38 0 DC @GP38@
Xntg38 out gn38 n26 0 sky130_fd_pr__nfet_01v8 w=1.1u l=0.16u
Xptg38 out gp38 n26 vref sky130_fd_pr__pfet_01v8 w=1.1u l=0.16u
Vgn39 gn39 0 DC @GN39@
Vgp39 gp39 0 DC @GP39@
Xntg39 out gn39 n25 0 sky130_fd_pr__nfet_01v8 w=1.1u l=0.16u
Xptg39 out gp39 n25 vref sky130_fd_pr__pfet_01v8 w=1.1u l=0.16u
Vgn40 gn40 0 DC @GN40@
Vgp40 gp40 0 DC @GP40@
Xntg40 out gn40 n24 0 sky130_fd_pr__nfet_01v8 w=1.1u l=0.16u
Xptg40 out gp40 n24 vref sky130_fd_pr__pfet_01v8 w=1.1u l=0.16u
Vgn41 gn41 0 DC @GN41@
Vgp41 gp41 0 DC @GP41@
Xntg41 out gn41 n23 0 sky130_fd_pr__nfet_01v8 w=1.1u l=0.16u
Xptg41 out gp41 n23 vref sky130_fd_pr__pfet_01v8 w=1.1u l=0.16u
Vgn42 gn42 0 DC @GN42@
Vgp42 gp42 0 DC @GP42@
Xntg42 out gn42 n22 0 sky130_fd_pr__nfet_01v8 w=1.1u l=0.16u
Xptg42 out gp42 n22 vref sky130_fd_pr__pfet_01v8 w=1.1u l=0.16u
Vgn43 gn43 0 DC @GN43@
Vgp43 gp43 0 DC @GP43@
Xntg43 out gn43 n21 0 sky130_fd_pr__nfet_01v8 w=1.1u l=0.16u
Xptg43 out gp43 n21 vref sky130_fd_pr__pfet_01v8 w=1.1u l=0.16u
Vgn44 gn44 0 DC @GN44@
Vgp44 gp44 0 DC @GP44@
Xntg44 out gn44 n20 0 sky130_fd_pr__nfet_01v8 w=1.1u l=0.16u
Xptg44 out gp44 n20 vref sky130_fd_pr__pfet_01v8 w=1.1u l=0.16u
Vgn45 gn45 0 DC @GN45@
Vgp45 gp45 0 DC @GP45@
Xntg45 out gn45 n19 0 sky130_fd_pr__nfet_01v8 w=1.1u l=0.16u
Xptg45 out gp45 n19 vref sky130_fd_pr__pfet_01v8 w=1.1u l=0.16u
Vgn46 gn46 0 DC @GN46@
Vgp46 gp46 0 DC @GP46@
Xntg46 out gn46 n18 0 sky130_fd_pr__nfet_01v8 w=1.1u l=0.16u
Xptg46 out gp46 n18 vref sky130_fd_pr__pfet_01v8 w=1.1u l=0.16u
Vgn47 gn47 0 DC @GN47@
Vgp47 gp47 0 DC @GP47@
Xntg47 out gn47 n17 0 sky130_fd_pr__nfet_01v8 w=1.1u l=0.16u
Xptg47 out gp47 n17 vref sky130_fd_pr__pfet_01v8 w=1.1u l=0.16u
Vgn48 gn48 0 DC @GN48@
Vgp48 gp48 0 DC @GP48@
Xntg48 out gn48 n16 0 sky130_fd_pr__nfet_01v8 w=1.1u l=0.16u
Xptg48 out gp48 n16 vref sky130_fd_pr__pfet_01v8 w=1.1u l=0.16u
Vgn49 gn49 0 DC @GN49@
Vgp49 gp49 0 DC @GP49@
Xntg49 out gn49 n15 0 sky130_fd_pr__nfet_01v8 w=1.1u l=0.16u
Xptg49 out gp49 n15 vref sky130_fd_pr__pfet_01v8 w=1.1u l=0.16u
Vgn50 gn50 0 DC @GN50@
Vgp50 gp50 0 DC @GP50@
Xntg50 out gn50 n14 0 sky130_fd_pr__nfet_01v8 w=1.1u l=0.16u
Xptg50 out gp50 n14 vref sky130_fd_pr__pfet_01v8 w=1.1u l=0.16u
Vgn51 gn51 0 DC @GN51@
Vgp51 gp51 0 DC @GP51@
Xntg51 out gn51 n13 0 sky130_fd_pr__nfet_01v8 w=1.1u l=0.16u
Xptg51 out gp51 n13 vref sky130_fd_pr__pfet_01v8 w=1.1u l=0.16u
Vgn52 gn52 0 DC @GN52@
Vgp52 gp52 0 DC @GP52@
Xntg52 out gn52 n12 0 sky130_fd_pr__nfet_01v8 w=1.1u l=0.16u
Xptg52 out gp52 n12 vref sky130_fd_pr__pfet_01v8 w=1.1u l=0.16u
Vgn53 gn53 0 DC @GN53@
Vgp53 gp53 0 DC @GP53@
Xntg53 out gn53 n11 0 sky130_fd_pr__nfet_01v8 w=1.1u l=0.16u
Xptg53 out gp53 n11 vref sky130_fd_pr__pfet_01v8 w=1.1u l=0.16u
Vgn54 gn54 0 DC @GN54@
Vgp54 gp54 0 DC @GP54@
Xntg54 out gn54 n10 0 sky130_fd_pr__nfet_01v8 w=1.1u l=0.16u
Xptg54 out gp54 n10 vref sky130_fd_pr__pfet_01v8 w=1.1u l=0.16u
Vgn55 gn55 0 DC @GN55@
Vgp55 gp55 0 DC @GP55@
Xntg55 out gn55 n9 0 sky130_fd_pr__nfet_01v8 w=1.1u l=0.16u
Xptg55 out gp55 n9 vref sky130_fd_pr__pfet_01v8 w=1.1u l=0.16u
Vgn56 gn56 0 DC @GN56@
Vgp56 gp56 0 DC @GP56@
Xntg56 out gn56 n8 0 sky130_fd_pr__nfet_01v8 w=1.1u l=0.16u
Xptg56 out gp56 n8 vref sky130_fd_pr__pfet_01v8 w=1.1u l=0.16u
Vgn57 gn57 0 DC @GN57@
Vgp57 gp57 0 DC @GP57@
Xntg57 out gn57 n7 0 sky130_fd_pr__nfet_01v8 w=1.1u l=0.16u
Xptg57 out gp57 n7 vref sky130_fd_pr__pfet_01v8 w=1.1u l=0.16u
Vgn58 gn58 0 DC @GN58@
Vgp58 gp58 0 DC @GP58@
Xntg58 out gn58 n6 0 sky130_fd_pr__nfet_01v8 w=1.1u l=0.16u
Xptg58 out gp58 n6 vref sky130_fd_pr__pfet_01v8 w=1.1u l=0.16u
Vgn59 gn59 0 DC @GN59@
Vgp59 gp59 0 DC @GP59@
Xntg59 out gn59 n5 0 sky130_fd_pr__nfet_01v8 w=1.1u l=0.16u
Xptg59 out gp59 n5 vref sky130_fd_pr__pfet_01v8 w=1.1u l=0.16u
Vgn60 gn60 0 DC @GN60@
Vgp60 gp60 0 DC @GP60@
Xntg60 out gn60 n4 0 sky130_fd_pr__nfet_01v8 w=1.1u l=0.16u
Xptg60 out gp60 n4 vref sky130_fd_pr__pfet_01v8 w=1.1u l=0.16u
Vgn61 gn61 0 DC @GN61@
Vgp61 gp61 0 DC @GP61@
Xntg61 out gn61 n3 0 sky130_fd_pr__nfet_01v8 w=1.1u l=0.16u
Xptg61 out gp61 n3 vref sky130_fd_pr__pfet_01v8 w=1.1u l=0.16u
Vgn62 gn62 0 DC @GN62@
Vgp62 gp62 0 DC @GP62@
Xntg62 out gn62 n2 0 sky130_fd_pr__nfet_01v8 w=1.1u l=0.16u
Xptg62 out gp62 n2 vref sky130_fd_pr__pfet_01v8 w=1.1u l=0.16u
Vgn63 gn63 0 DC @GN63@
Vgp63 gp63 0 DC @GP63@
Xntg63 out gn63 n1 0 sky130_fd_pr__nfet_01v8 w=1.1u l=0.16u
Xptg63 out gp63 n1 vref sky130_fd_pr__pfet_01v8 w=1.1u l=0.16u

.control
  op
  print col v(out) > raw/dac6_last.txt
quit
.endc
.end
